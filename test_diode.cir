Diode Half-Wave Rectifier
V1 1 0 DC 10
R1 1 2 1k
D1 2 3 DMOD
R2 3 0 10k
.MODEL DMOD D
.OP
.END

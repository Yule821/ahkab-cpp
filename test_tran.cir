RC Charging Transient
V1 1 0 DC 5
R1 1 2 1k
C1 2 0 1n
.TRAN 0.1u 10u
.END

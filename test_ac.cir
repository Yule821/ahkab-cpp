RC Low Pass Filter
V1 1 0 DC 1 AC 1 0
R1 1 2 1k
C1 2 0 1u
.AC DEC 5 10 100k
.END
